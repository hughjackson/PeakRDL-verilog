
addrmap sw_access {
    default swmod;
    default swacc;

    reg {
        default sw = rw;
        default hw = rw;
        default fieldwidth = 2;
        field {onread =rclr;  } frclr;
        field {onread =rset;  } frset;
        field {onwrite=woset; } fwoset;
        field {onwrite=woclr; } fwoclr;
        field {onwrite=wot;   } fwot;
        field {onwrite=wzs;   } fwzs;
        field {onwrite=wzc;   } fwzc;
        field {onwrite=wzt;   } fwzt;
        field {onwrite=wclr;  } fwclr;
        field {onwrite=wset;  } fwset;
        field {singlepulse; fieldwidth=1; sw=w;} single=0;
    } onreadwrite;

    reg {
        default sw = rw;
        field { swwe;} swwe_true;
        field { swwel;} swwel_true;
        field { } swwe_ref;
        field { } swwel_ref;
        field { } we;
        field { } wel;

        //swwe_ref->swwe = we;
        swwel_ref->swwel = wel;
    } swwe;


};
